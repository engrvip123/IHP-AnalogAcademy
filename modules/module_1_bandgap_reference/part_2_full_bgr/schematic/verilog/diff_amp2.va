// importing libs

`include "discipline.h"

module diff_amp (out, IN1, IN2);

output electrical out;

input electrical IN1, IN2;

parameter real gain = 10000; // setting gain to 10 of the differential amplifier

analog begin

    V(out) <+ gain * (V(IN1) - V(IN2));

end

endmodule
